*SPICE Netlist for circuit 13
V1 1 0 5V
M2 1 2 0 0 PMOS W=1u L=1u
M1 1 1 VDD VDD NMOS W=1u L=1u
.MODEL NMOS NMOS (LEVEL=1 VTO=1 KP=1.0e-4 LAMBDA=0.02)
.MODEL PMOS PMOS (LEVEL=1 VTO=1 KP=1.0e-4 LAMBDA=0.02)

.OP
.END
