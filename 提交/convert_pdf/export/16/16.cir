*SPICE Netlist for circuit 16
V2 0 7 5V
V1 8 0 5V
R2 1 3 1k
R3 1 VDD 1k
M2 1 8 3 3 PMOS W=1u L=1u
R4 4 2 1k
R1 2 VDD 1k
M1 2 7 4 4 NMOS W=1u L=1u
.MODEL NMOS NMOS (LEVEL=1 VTO=1 KP=1.0e-4 LAMBDA=0.02)
.MODEL PMOS PMOS (LEVEL=1 VTO=1 KP=1.0e-4 LAMBDA=0.02)

.OP
.END
