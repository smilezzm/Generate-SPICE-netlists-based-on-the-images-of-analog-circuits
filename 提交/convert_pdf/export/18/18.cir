*SPICE Netlist for circuit 18
I1 1 0 DC 1mA
V1 0 2 5V
M1 4 2 1 1 PMOS W=1u L=1u
M2 3 2 1 1 PMOS W=1u L=1u
R4 3 1 1k
R2 3 VDD 1k
R3 1 4 1k
R1 4 VDD 1k
.MODEL PMOS PMOS (LEVEL=1 VTO=1 KP=1.0e-4 LAMBDA=0.02)

.OP
.END
