*SPICE Netlist for circuit 19
R3 0 1 1k
M1 2 4 1 1 NMOS W=1u L=1u
M2 2 4 1 1 NMOS W=1u L=1u
R2 2 VDD 1k
R1 2 VDD 1k
.MODEL NMOS NMOS (LEVEL=1 VTO=1 KP=1.0e-4 LAMBDA=0.02)

.OP
.END
