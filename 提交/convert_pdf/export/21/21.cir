*SPICE Netlist for circuit 21
I1 3 0 DC 1mA
M3 4 8 1 1 NMOS W=1u L=1u
M1 7 10 1 1 NMOS W=1u L=1u
M4 7 9 2 2 NMOS W=1u L=1u
M2 6 11 2 2 NMOS W=1u L=1u
M5 1 12 3 3 NMOS W=1u L=1u
M6 2 14 3 3 PMOS W=1u L=1u
R1 4 VDD 1k
R2 6 VDD 1k
.MODEL NMOS NMOS (LEVEL=1 VTO=1 KP=1.0e-4 LAMBDA=0.02)
.MODEL PMOS PMOS (LEVEL=1 VTO=1 KP=1.0e-4 LAMBDA=0.02)

.OP
.END
