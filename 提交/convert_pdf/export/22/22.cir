*SPICE Netlist for circuit 22
I1 19 0 DC 1mA
M1 6 9 1 1 NMOS W=1u L=1u
M4 1 11 2 2 NMOS W=1u L=1u
M6 5 2 2 2 PMOS W=1u L=1u
R2 3 VDD 1k
M2 3 10 1 1 NMOS W=1u L=1u
M3 3 9 5 5 NMOS W=1u L=1u
M5 6 10 5 5 PMOS W=1u L=1u
R1 6 VDD 1k
.MODEL NMOS NMOS (LEVEL=1 VTO=1 KP=1.0e-4 LAMBDA=0.02)
.MODEL PMOS PMOS (LEVEL=1 VTO=1 KP=1.0e-4 LAMBDA=0.02)

.OP
.END
