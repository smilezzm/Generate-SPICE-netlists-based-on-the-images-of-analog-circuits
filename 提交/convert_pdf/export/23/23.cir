*SPICE Netlist for circuit 23
M2 1 11 0 0 NMOS W=1u L=1u
M7 2 13 1 1 PMOS W=1u L=1u
M1 4 10 1 1 NMOS W=1u L=1u
M3 2 2 VDD VDD PMOS W=1u L=1u
M6 4 8 VDD VDD PMOS W=1u L=1u
M5 4 4 VDD VDD PMOS W=1u L=1u
M4 2 12 VDD VDD PMOS W=1u L=1u
.MODEL NMOS NMOS (LEVEL=1 VTO=1 KP=1.0e-4 LAMBDA=0.02)
.MODEL PMOS PMOS (LEVEL=1 VTO=1 KP=1.0e-4 LAMBDA=0.02)

.OP
.END
