*SPICE Netlist for circuit 24
M2 1 9 0 0 NMOS W=1u L=1u
M1 4 21 1 1 NMOS W=1u L=1u
M7 2 11 1 1 PMOS W=1u L=1u
M4 2 2 VDD VDD PMOS W=1u L=1u
M5 4 4 VDD VDD PMOS W=1u L=1u
M6 2 14 VDD VDD PMOS W=1u L=1u
M3 4 13 VDD VDD PMOS W=1u L=1u
.MODEL NMOS NMOS (LEVEL=1 VTO=1 KP=1.0e-4 LAMBDA=0.02)
.MODEL PMOS PMOS (LEVEL=1 VTO=1 KP=1.0e-4 LAMBDA=0.02)

.OP
.END
