*SPICE Netlist for circuit 25
M3 2 7 0 0 NMOS W=1u L=1u
M1 1 1 2 2 NMOS W=1u L=1u
M2 3 6 2 2 NMOS W=1u L=1u
M4 3 3 VDD VDD PMOS W=1u L=1u
M5 1 3 VDD VDD PMOS W=1u L=1u
.MODEL NMOS NMOS (LEVEL=1 VTO=1 KP=1.0e-4 LAMBDA=0.02)
.MODEL PMOS PMOS (LEVEL=1 VTO=1 KP=1.0e-4 LAMBDA=0.02)

.OP
.END
