*SPICE Netlist for circuit 27
C1 8 3 1nF
I1 VDD 2 DC 1mA
I2 6 0 DC 1mA
M2 1 3 0 0 NMOS W=1u L=1u
M1 2 2 0 0 NMOS W=1u L=1u
R2 6 1 1k
M3 1 6 VDD VDD PMOS W=1u L=1u
R1 2 3 1k
.MODEL NMOS NMOS (LEVEL=1 VTO=1 KP=1.0e-4 LAMBDA=0.02)
.MODEL PMOS PMOS (LEVEL=1 VTO=1 KP=1.0e-4 LAMBDA=0.02)

.OP
.END
