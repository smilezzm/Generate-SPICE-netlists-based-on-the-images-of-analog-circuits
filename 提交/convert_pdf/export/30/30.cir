*SPICE Netlist for circuit 30
U1 1 2

.OP
.END
