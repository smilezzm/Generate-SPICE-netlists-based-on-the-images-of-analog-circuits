*SPICE Netlist for circuit 34
C1 0 1 1nF
C2 0 2 1nF
C3 3 2 1nF
R1 1 3 1k
V1 0 4 5V
R2 4 1 1k
U1 1 5
R3 5 2 1k

.OP
.END
