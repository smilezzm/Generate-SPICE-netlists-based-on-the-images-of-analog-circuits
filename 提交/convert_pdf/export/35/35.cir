*SPICE Netlist for circuit 35
M1 1 2 0 0 PMOS W=1u L=1u
R1 1 VDD 1k
.MODEL PMOS PMOS (LEVEL=1 VTO=1 KP=1.0e-4 LAMBDA=0.02)

.OP
.END
