*SPICE Netlist for circuit 37
I1 0 1 DC 1mA
R1 1 1k
U1 2 1 3

.OP
.END
