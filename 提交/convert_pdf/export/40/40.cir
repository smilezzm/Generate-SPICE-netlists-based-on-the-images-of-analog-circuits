*SPICE Netlist for circuit 40
R2 0 2 1k
U1 2 3 1
R1 2 1 1k

.OP
.END
