*SPICE Netlist for circuit 41
C1 1 2 1nF
C2 3 1 1nF
U1 0 1 2

.OP
.END
