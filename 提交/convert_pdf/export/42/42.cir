*SPICE Netlist for circuit 42
R1 0 1 1k
U1 1 3 5
M1 2 5 1 1 NMOS W=1u L=1u
R2 2 VDD 1k
.MODEL NMOS NMOS (LEVEL=1 VTO=1 KP=1.0e-4 LAMBDA=0.02)

.OP
.END
