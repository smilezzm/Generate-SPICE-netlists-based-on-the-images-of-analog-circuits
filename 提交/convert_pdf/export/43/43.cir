*SPICE Netlist for circuit 43
R2 0 2 1k
R1 0 1 1k
M1 1 5 VDD VDD PMOS W=1u L=1u
U1 2 3 5
.MODEL PMOS PMOS (LEVEL=1 VTO=1 KP=1.0e-4 LAMBDA=0.02)

.OP
.END
