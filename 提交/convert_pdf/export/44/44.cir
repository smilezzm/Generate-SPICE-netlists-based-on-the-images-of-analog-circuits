*SPICE Netlist for circuit 44
R1 0 1 1k
U1 1 2 3
M1 1 3 VDD VDD PMOS W=1u L=1u
.MODEL PMOS PMOS (LEVEL=1 VTO=1 KP=1.0e-4 LAMBDA=0.02)

.OP
.END
