*SPICE Netlist for circuit 47
V1 1 0 5V

.OP
.END
