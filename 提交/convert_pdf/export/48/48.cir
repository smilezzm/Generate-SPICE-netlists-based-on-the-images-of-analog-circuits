*SPICE Netlist for circuit 48
V1 5 0 5V
R1 6 1 1k
U1 4 VDD
R2 5 6 1k

.OP
.END
