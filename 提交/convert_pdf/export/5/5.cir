*SPICE Netlist for circuit 5
I1 2 0 DC 1mA
V1 0 1 5V
M1 1 3 2 2 NMOS W=1u L=1u
R1 2 1 1k
.MODEL NMOS NMOS (LEVEL=1 VTO=1 KP=1.0e-4 LAMBDA=0.02)

.OP
.END
