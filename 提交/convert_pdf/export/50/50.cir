*SPICE Netlist for circuit 50
I1 10 0 DC 1mA
M6 11 7 1 1 NMOS W=1u L=1u
M2 12 1 1 1 NMOS W=1u L=1u
M8 5 2 13 13 PMOS W=1u L=1u
M1 5 3 11 11 NMOS W=1u L=1u
M4 4 2 16 16 NMOS W=1u L=1u
M5 4 3 12 12 NMOS W=1u L=1u
M7 13 6 VDD VDD PMOS W=1u L=1u
M3 16 6 VDD VDD NMOS W=1u L=1u
.MODEL NMOS NMOS (LEVEL=1 VTO=1 KP=1.0e-4 LAMBDA=0.02)
.MODEL PMOS PMOS (LEVEL=1 VTO=1 KP=1.0e-4 LAMBDA=0.02)

.OP
.END
