*SPICE Netlist for circuit 51
I1 VDD 5 DC 1mA
M9 3 12 0 0 PMOS W=1u L=1u
M5 2 12 0 0 NMOS W=1u L=1u
M2 1 7 17 17 NMOS W=1u L=1u
M4 1 9 2 2 NMOS W=1u L=1u
M7 4 7 18 18 PMOS W=1u L=1u
M8 4 9 2 2 PMOS W=1u L=1u
M3 3 10 5 5 NMOS W=1u L=1u
M10 15 11 5 5 PMOS W=1u L=1u
M6 18 6 VDD VDD PMOS W=1u L=1u
M1 17 6 VDD VDD NMOS W=1u L=1u
.MODEL NMOS NMOS (LEVEL=1 VTO=1 KP=1.0e-4 LAMBDA=0.02)
.MODEL PMOS PMOS (LEVEL=1 VTO=1 KP=1.0e-4 LAMBDA=0.02)

.OP
.END
