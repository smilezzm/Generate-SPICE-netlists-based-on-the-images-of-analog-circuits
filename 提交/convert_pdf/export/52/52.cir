*SPICE Netlist for circuit 52
V1 1 0 5V
R2 0 2 1k
U1 0 3
M1 1 3 2 2 PMOS W=1u L=1u
R1 2 1 1k
.MODEL PMOS PMOS (LEVEL=1 VTO=1 KP=1.0e-4 LAMBDA=0.02)

.OP
.END
