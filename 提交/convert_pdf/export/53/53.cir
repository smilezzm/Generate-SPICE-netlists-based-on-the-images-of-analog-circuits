*SPICE Netlist for circuit 53
V1 1 0 5V
R1 2 0 1k
U1 0 4
R2 1 2 1k
M1 2 4 1 1 NMOS W=1u L=1u
.MODEL NMOS NMOS (LEVEL=1 VTO=1 KP=1.0e-4 LAMBDA=0.02)

.OP
.END
