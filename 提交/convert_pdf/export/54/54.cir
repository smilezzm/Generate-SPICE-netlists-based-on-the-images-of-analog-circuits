*SPICE Netlist for circuit 54
I1 VDD 2 DC 1mA
M2 1 5 0 0 NMOS W=1u L=1u
U1 1 6
M1 2 6 1 1 NMOS W=1u L=1u
.MODEL NMOS NMOS (LEVEL=1 VTO=1 KP=1.0e-4 LAMBDA=0.02)

.OP
.END
