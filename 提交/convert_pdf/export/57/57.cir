*SPICE Netlist for circuit 57
I1 7 0 DC 1mA
M4 2 4 1 1 NMOS W=1u L=1u
M2 3 1 1 1 NMOS W=1u L=1u
U1 2 10
M3 8 10 2 2 NMOS W=1u L=1u
U2 3 11
M1 9 11 3 3 NMOS W=1u L=1u
.MODEL NMOS NMOS (LEVEL=1 VTO=1 KP=1.0e-4 LAMBDA=0.02)

.OP
.END
