*SPICE Netlist for circuit 59
M2 2 2 0 0 NMOS W=1u L=1u
M7 1 2 0 0 PMOS W=1u L=1u
M4 7 7 1 1 NMOS W=1u L=1u
M1 6 6 1 1 NMOS W=1u L=1u
M6 3 3 VDD VDD PMOS W=1u L=1u
R1 2 3 1k
M5 7 3 VDD VDD PMOS W=1u L=1u
M3 6 3 VDD VDD NMOS W=1u L=1u
.MODEL NMOS NMOS (LEVEL=1 VTO=1 KP=1.0e-4 LAMBDA=0.02)
.MODEL PMOS PMOS (LEVEL=1 VTO=1 KP=1.0e-4 LAMBDA=0.02)

.OP
.END
