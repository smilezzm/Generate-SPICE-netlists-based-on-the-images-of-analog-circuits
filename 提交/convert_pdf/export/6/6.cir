*SPICE Netlist for circuit 6
M1 VDD 2 1 1 PMOS W=1u L=1u
V1 0 1 5V
R2 1 2 1k
R1 2 VDD 1k
.MODEL PMOS PMOS (LEVEL=1 VTO=1 KP=1.0e-4 LAMBDA=0.02)

.OP
.END
