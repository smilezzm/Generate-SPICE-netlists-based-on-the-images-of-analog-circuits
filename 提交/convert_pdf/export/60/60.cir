*SPICE Netlist for circuit 60
I1 7 0 DC 1mA
I2 6 0 DC 1mA
M4 17 13 0 0 NMOS W=1u L=1u
M2 18 13 0 0 NMOS W=1u L=1u
R1 6 1 1k
R2 1 1 1k
M3 VDD 2 7 7 NMOS W=1u L=1u
M7 2 14 20 20 PMOS W=1u L=1u
M6 VDD 4 6 6 NMOS W=1u L=1u
M5 4 14 22 22 NMOS W=1u L=1u
M1 2 15 17 17 NMOS W=1u L=1u
M10 4 15 18 18 PMOS W=1u L=1u
M8 22 16 VDD VDD PMOS W=1u L=1u
M9 20 16 VDD VDD PMOS W=1u L=1u
.MODEL NMOS NMOS (LEVEL=1 VTO=1 KP=1.0e-4 LAMBDA=0.02)
.MODEL PMOS PMOS (LEVEL=1 VTO=1 KP=1.0e-4 LAMBDA=0.02)

.OP
.END
