*SPICE Netlist for circuit 61
I1 14 0 DC 1mA
M4 18 19 0 0 NMOS W=1u L=1u
M2 20 21 0 0 NMOS W=1u L=1u
M7 1 15 VDD VDD PMOS W=1u L=1u
M9 7 16 1 1 PMOS W=1u L=1u
R2 6 2 1k
R1 2 7 1k
M5 5 9 3 3 NMOS W=1u L=1u
M10 1 3 3 3 PMOS W=1u L=1u
U1 2 4 21
M8 5 15 VDD VDD PMOS W=1u L=1u
M3 6 16 5 5 NMOS W=1u L=1u
M1 6 17 18 18 NMOS W=1u L=1u
M6 7 17 20 20 NMOS W=1u L=1u
.MODEL NMOS NMOS (LEVEL=1 VTO=1 KP=1.0e-4 LAMBDA=0.02)
.MODEL PMOS PMOS (LEVEL=1 VTO=1 KP=1.0e-4 LAMBDA=0.02)

.OP
.END
