*SPICE Netlist for circuit 62
M10 3 18 0 0 PMOS W=1u L=1u
M11 19 14 0 0 PMOS W=1u L=1u
M2 20 14 0 0 NMOS W=1u L=1u
R1 6 1 1k
R2 1 7 1k
U1 1 2 10
M4 4 9 3 3 NMOS W=1u L=1u
M9 5 22 3 3 PMOS W=1u L=1u
M6 4 15 VDD VDD PMOS W=1u L=1u
M5 5 15 VDD VDD PMOS W=1u L=1u
M8 7 16 5 5 PMOS W=1u L=1u
M3 6 16 4 4 NMOS W=1u L=1u
M7 7 17 20 20 PMOS W=1u L=1u
M1 6 17 19 19 NMOS W=1u L=1u
.MODEL NMOS NMOS (LEVEL=1 VTO=1 KP=1.0e-4 LAMBDA=0.02)
.MODEL PMOS PMOS (LEVEL=1 VTO=1 KP=1.0e-4 LAMBDA=0.02)

.OP
.END
