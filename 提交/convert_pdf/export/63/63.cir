*SPICE Netlist for circuit 63
I1 8 0 DC 1mA
M4 3 1 8 8 PMOS W=1u L=1u
M1 4 6 0 0 PMOS W=1u L=1u
U1 2 7
M3 4 3 VDD VDD PMOS W=1u L=1u
M2 3 5 VDD VDD PMOS W=1u L=1u
R1 9 4 1k
.MODEL PMOS PMOS (LEVEL=1 VTO=1 KP=1.0e-4 LAMBDA=0.02)

.OP
.END
