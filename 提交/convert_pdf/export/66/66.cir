*SPICE Netlist for circuit 66
M5 8 10 1 1 PMOS W=1u L=1u
M4 4 2 1 1 PMOS W=1u L=1u
M3 2 11 VDD VDD PMOS W=1u L=1u
M1 9 10 2 2 NMOS W=1u L=1u
M6 4 1 2 2 PMOS W=1u L=1u
M2 1 11 VDD VDD PMOS W=1u L=1u
.MODEL NMOS NMOS (LEVEL=1 VTO=1 KP=1.0e-4 LAMBDA=0.02)
.MODEL PMOS PMOS (LEVEL=1 VTO=1 KP=1.0e-4 LAMBDA=0.02)

.OP
.END
