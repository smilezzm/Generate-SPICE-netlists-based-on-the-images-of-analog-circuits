*SPICE Netlist for circuit 67
C1 0 3 1nF
C2 0 6 1nF
M8 3 15 0 0 PMOS W=1u L=1u
M1 16 15 0 0 NMOS W=1u L=1u
M3 9 7 0 0 PMOS W=1u L=1u
M2 6 7 0 0 NMOS W=1u L=1u
M4 16 1 VDD VDD PMOS W=1u L=1u
M6 1 1 VDD VDD PMOS W=1u L=1u
M5 2 2 VDD VDD PMOS W=1u L=1u
M7 13 2 VDD VDD PMOS W=1u L=1u
.MODEL NMOS NMOS (LEVEL=1 VTO=1 KP=1.0e-4 LAMBDA=0.02)
.MODEL PMOS PMOS (LEVEL=1 VTO=1 KP=1.0e-4 LAMBDA=0.02)

.OP
.END
