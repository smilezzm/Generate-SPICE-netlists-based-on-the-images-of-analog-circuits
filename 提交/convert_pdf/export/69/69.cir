*SPICE Netlist for circuit 69
I1 VDD 10 DC 1mA
M11 1 20 0 0 PMOS W=1u L=1u
M6 2 22 0 0 PMOS W=1u L=1u
M12 11 5 0 0 PMOS W=1u L=1u
M1 9 4 0 0 NMOS W=1u L=1u
M2 5 15 0 0 PMOS W=1u L=1u
M7 4 15 0 0 PMOS W=1u L=1u
M3 11 1 VDD VDD PMOS W=1u L=1u
M8 1 1 VDD VDD PMOS W=1u L=1u
M4 2 2 VDD VDD PMOS W=1u L=1u
M9 9 2 VDD VDD PMOS W=1u L=1u
M10 5 12 10 10 PMOS W=1u L=1u
M5 4 14 10 10 PMOS W=1u L=1u
.MODEL NMOS NMOS (LEVEL=1 VTO=1 KP=1.0e-4 LAMBDA=0.02)
.MODEL PMOS PMOS (LEVEL=1 VTO=1 KP=1.0e-4 LAMBDA=0.02)

.OP
.END
