*SPICE Netlist for circuit 70
I1 VDD 8 DC 1mA
I2 VDD 26 DC 1mA
M10 1 4 0 0 PMOS W=1u L=1u
M2 2 7 0 0 NMOS W=1u L=1u
M5 4 13 0 0 PMOS W=1u L=1u
M3 7 13 0 0 NMOS W=1u L=1u
M6 1 25 VDD VDD PMOS W=1u L=1u
M9 4 10 3 3 PMOS W=1u L=1u
M7 7 12 3 3 PMOS W=1u L=1u
M8 2 9 VDD VDD PMOS W=1u L=1u
M1 2 10 8 8 NMOS W=1u L=1u
M4 1 12 26 26 PMOS W=1u L=1u
.MODEL NMOS NMOS (LEVEL=1 VTO=1 KP=1.0e-4 LAMBDA=0.02)
.MODEL PMOS PMOS (LEVEL=1 VTO=1 KP=1.0e-4 LAMBDA=0.02)

.OP
.END
