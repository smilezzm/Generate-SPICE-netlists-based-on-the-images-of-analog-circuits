*SPICE Netlist for circuit 72
C1 1 2 1nF
U2 2 3 1
U1 1 2

.OP
.END
