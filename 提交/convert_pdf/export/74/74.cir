*SPICE Netlist for circuit 74
C1 3 2 1nF
I1 VDD 1 DC 1mA
M1 1 3 0 0 PMOS W=1u L=1u
M2 VDD 1 2 2 PMOS W=1u L=1u
U1 5 6 3
.MODEL PMOS PMOS (LEVEL=1 VTO=1 KP=1.0e-4 LAMBDA=0.02)

.OP
.END
