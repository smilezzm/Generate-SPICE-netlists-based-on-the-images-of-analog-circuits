*SPICE Netlist for circuit 75
C1 1 2 1nF
I1 VDD 1 DC 1mA
I2 VDD 2 DC 1mA
I3 3 0 DC 1mA
M1 2 3 0 0 PMOS W=1u L=1u
M2 3 4 1 1 PMOS W=1u L=1u
R1 7 3 1k
U1 5 6 7
.MODEL PMOS PMOS (LEVEL=1 VTO=1 KP=1.0e-4 LAMBDA=0.02)

.OP
.END
