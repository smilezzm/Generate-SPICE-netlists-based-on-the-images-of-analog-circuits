*SPICE Netlist for circuit 76
I1 1 0 DC 1mA
M4 4 6 VDD VDD PMOS W=1u L=1u
M2 5 10 VDD VDD PMOS W=1u L=1u
M6 5 9 1 1 PMOS W=1u L=1u
M1 4 8 1 1 NMOS W=1u L=1u
M3 4 4 VDD VDD PMOS W=1u L=1u
M5 5 5 VDD VDD PMOS W=1u L=1u
.MODEL NMOS NMOS (LEVEL=1 VTO=1 KP=1.0e-4 LAMBDA=0.02)
.MODEL PMOS PMOS (LEVEL=1 VTO=1 KP=1.0e-4 LAMBDA=0.02)

.OP
.END
